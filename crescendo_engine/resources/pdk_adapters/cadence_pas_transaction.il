procedure(crescPdkApplyParameter(inst paramName value)
  let((cdfgData baseCdf cdfParam paramSymbol formResult setResult callbackResult doneResult)
    unless(dbIsId(inst)
      error("CRESCENDO_ADAPTER_ERROR:cdf_update_api_incompatible invalid instance\n"))
    unless(isCallable('PasCdfFormInit) && isCallable('PasCdfSetValue) && isCallable('PasCdfCallCallbacks) && isCallable('PasCdfDone)
      error("CRESCENDO_ADAPTER_ERROR:cdf_update_api_incompatible PAS transaction API unavailable\n"))
    cdfgData = cdfGetInstCDF(inst)
    unless(cdfgData
      error("CRESCENDO_ADAPTER_ERROR:cdf_parameter_mapping_incompatible instance CDF unavailable\n"))
    baseCdf = cdfGetBaseCellCDF(ddGetObj(inst~>master~>libName inst~>master~>cellName))
    paramSymbol = stringToSymbol(paramName)
    cdfParam = get(cdfgData paramSymbol)
    unless(cdfParam
      error("CRESCENDO_ADAPTER_ERROR:cdf_parameter_mapping_incompatible CDF parameter missing: %s\n" paramName))
    formResult = errset(PasCdfFormInit(cdfgData) t)
    unless(formResult && car(formResult)
      error("CRESCENDO_ADAPTER_ERROR:cdf_update_api_incompatible PAS form initialization failed: %s\n" paramName))
    setResult = errset(PasCdfSetValue(cdfParam value nil) t)
    callbackResult = errset(PasCdfCallCallbacks(inst list(paramSymbol)) t)
    doneResult = errset(PasCdfDone(inst) t)
    unless(setResult && car(setResult)
      error("CRESCENDO_ADAPTER_ERROR:cdf_parameter_mapping_incompatible PAS value assignment failed: %s\n" paramName))
    unless(callbackResult && car(callbackResult)
      error("CRESCENDO_ADAPTER_ERROR:cdf_callback_incompatible PAS callback transaction failed: %s\n" paramName))
    unless(doneResult && car(doneResult)
      error("CRESCENDO_ADAPTER_ERROR:cdf_update_api_incompatible PAS transaction cleanup failed: %s\n" paramName))
    t
  )
)
